** Profile: "SCHEMATIC1-DCSweep"  [ D:\YandexDisk\SSS_WorkHome\SSS_OrCad PSpice\005_ParametricSweep\parametric sweep-pspicefiles\schematic1\dcsweep.sim ]

** Creating circuit file "DCSweep.cir"
** WARNING: THIS AUTOMATICALLY GENERATED FILE MAY BE OVERWRITTEN BY SUBSEQUENT SIMULATIONS

*Libraries:
* Profile Libraries :
* Local Libraries :
* From [PSPICE NETLIST] section of D:\Program Files\Cadence\SPB_Data\cdssetup\OrCAD_PSpice\17.4.0\PSpice.ini file:
.lib "nom.lib"

*Analysis directives:
.DC LIN PARAM rvariable 500 100k 500
.OPTIONS ADVCONV
.PROBE64 V(alias(*)) I(alias(*)) W(alias(*)) D(alias(*)) NOISE(alias(*))
.INC "..\SCHEMATIC1.net"

.END
